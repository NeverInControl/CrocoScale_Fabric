* NGSPICE file created from SwitchMatrixMultiplexer_rcx.ext - technology: ihp-sg13g2

.subckt SwitchMatrixMultiplexer_rcx D VSS VDD A B X SEL
X0 a_300_158# a_274_122# a_238_158# VSS.t0 sg13_lv_nmos ad=0.1045p pd=0.93u as=49.5f ps=0.73u w=0.55u l=0.13u
X1 a_402_158# D.t0 a_300_158# VSS.t10 sg13_lv_nmos ad=49.5f pd=0.73u as=0.1045p ps=0.93u w=0.55u l=0.13u
X2 a_754_96# A.t0 a_692_96# VSS.t12 sg13_lv_nmos ad=0.1045p pd=0.93u as=49.5f ps=0.73u w=0.55u l=0.13u
X3 VSS.t7 SEL.t0 a_42_158# VSS.t8 sg13_lv_nmos ad=0.1045p pd=0.93u as=0.187p ps=1.78u w=0.55u l=0.13u
X4 VSS.t4 SEL.t0 a_402_158# VSS.t9 sg13_lv_nmos ad=0.19125p pd=1.33u as=49.5f ps=0.73u w=0.55u l=0.13u
X5 a_274_122# a_300_158# VSS.t4 VSS.t3 sg13_lv_nmos ad=0.16545p pd=1.27u as=0.19125p ps=1.33u w=0.86u l=0.13u
X6 a_692_96# a_300_158# a_274_122# VSS.t5 sg13_lv_nmos ad=49.5f pd=0.73u as=0.16545p ps=1.27u w=0.55u l=0.13u
X7 X.t1 a_754_96# VDD.t1 VDD.t0 sg13_lv_pmos ad=0.4464p pd=3.2u as=0.241p ps=1.71u w=1.24u l=0.13u
X8 a_238_158# a_42_158# VSS.t7 VSS.t6 sg13_lv_nmos ad=49.5f pd=0.73u as=0.1045p ps=0.93u w=0.55u l=0.13u
X9 X.t0 a_754_96# VSS.t2 VSS.t13 sg13_lv_nmos ad=0.2952p pd=2.36u as=0.18325p ps=1.29u w=0.82u l=0.13u
X10 a_856_96# B.t0 a_754_96# VSS.t11 sg13_lv_nmos ad=49.5f pd=0.73u as=0.1045p ps=0.93u w=0.55u l=0.13u
X11 VSS.t2 a_274_122# a_856_96# VSS.t1 sg13_lv_nmos ad=0.18325p pd=1.29u as=49.5f ps=0.73u w=0.55u l=0.13u
X12 a_300_158# a_274_122# a_238_448# VDD.t0 sg13_lv_pmos ad=0.1596p pd=1.22u as=75.59999f ps=1.02u w=0.84u l=0.13u
X13 VDD.t1 a_274_122# a_856_452# VDD.t0 sg13_lv_pmos ad=0.241p pd=1.71u as=73.8f ps=1u w=0.82u l=0.13u
X14 a_402_448# D.t0 a_300_158# VDD.t0 sg13_lv_pmos ad=75.59999f pd=1.02u as=0.1596p ps=1.22u w=0.84u l=0.13u
X15 a_692_452# a_300_158# a_274_122# VDD.t0 sg13_lv_pmos ad=73.8f pd=1u as=0.2395p ps=1.65u w=0.82u l=0.13u
X16 VDD.t4 SEL.t0 a_42_158# VDD.t0 sg13_lv_pmos ad=0.1596p pd=1.22u as=0.2856p ps=2.36u w=0.84u l=0.13u
X17 VDD.t2 a_42_158# a_402_448# VDD.t0 sg13_lv_pmos ad=0.2434p pd=1.71u as=75.59999f ps=1.02u w=0.84u l=0.13u
X18 a_754_96# B.t1 a_692_452# VDD.t0 sg13_lv_pmos ad=0.1558p pd=1.2u as=73.8f ps=1u w=0.82u l=0.13u
X19 a_238_448# SEL.t0 VDD.t4 VDD.t0 sg13_lv_pmos ad=75.59999f pd=1.02u as=0.1596p ps=1.22u w=0.84u l=0.13u
X20 a_856_452# A.t0 a_754_96# VDD.t0 sg13_lv_pmos ad=73.8f pd=1u as=0.1558p ps=1.2u w=0.82u l=0.13u
X21 a_274_122# a_300_158# VDD.t2 VDD.t0 sg13_lv_pmos ad=0.2395p pd=1.65u as=0.2434p ps=1.71u w=1.24u l=0.13u
R0 X.n0 X.t1 9.4626
R1 X.n0 X.t0 8.47769
R2 X X.n0 0.125997
R3 A A.t0 15.7294
R4 B.n0 B.t1 15.1854
R5 B.n0 B.t0 15.0005
R6 B B.n0 0.0309255
R7 SEL SEL.t0 15.0428
R8 D.n0 D.t0 15.1896
R9 D.n0 D 0.116
R10 D D.n0 0.0520625
R11 VDD.n1 VDD.t1 17.887
R12 VDD.n0 VDD.t4 17.5574
R13 VDD.n2 VDD.t2 17.4849
R14 VDD.n5 VDD.n4 8.47111
R15 VDD.n4 VDD.n3 4.17719
R16 VDD.n4 VDD.n1 2.74387
R17 VDD.n4 VDD.t0 1.41717
R18 VDD.n2 VDD.n1 0.359802
R19 VDD.n3 VDD.n0 0.262011
R20 VDD.n3 VDD.n2 0.21278
R21 VDD VDD.n5 0.120789
R22 VDD.n5 VDD.n0 0.098289
R23 VSS.n4 VSS.t6 602.072
R24 VSS.n6 VSS.t9 568.966
R25 VSS.t12 VSS.n0 554.188
R26 VSS.t1 VSS.t11 458.128
R27 VSS.t5 VSS.n1 406.404
R28 VSS.t3 VSS.n1 391.627
R29 VSS.n5 VSS.t10 391.627
R30 VSS.n5 VSS.t0 362.07
R31 VSS.t0 VSS.n3 347.291
R32 VSS.n6 VSS.t3 317.735
R33 VSS.t10 VSS.n2 317.735
R34 VSS.n7 VSS.t5 302.957
R35 VSS.t11 VSS.n0 199.507
R36 VSS.n7 VSS.t12 155.173
R37 VSS.t9 VSS.n2 140.394
R38 VSS.n4 VSS.t8 119.234
R39 VSS.n8 VSS.t13 114.688
R40 VSS.t6 VSS.n3 110.838
R41 VSS.n8 VSS.t1 68.0224
R42 VSS.n13 VSS.t7 17.3601
R43 VSS.n11 VSS.t4 17.2882
R44 VSS.n9 VSS.n3 17.0005
R45 VSS.n9 VSS.n5 17.0005
R46 VSS.n9 VSS.n2 17.0005
R47 VSS.n9 VSS.n6 17.0005
R48 VSS.n9 VSS.n1 17.0005
R49 VSS.n9 VSS.n7 17.0005
R50 VSS.n9 VSS.n0 17.0005
R51 VSS.n9 VSS.n4 13.0636
R52 VSS.n10 VSS.t2 9.16023
R53 VSS.n14 VSS.n9 8.47111
R54 VSS.n12 VSS.n9 5.61485
R55 VSS.n10 VSS.n9 2.32906
R56 VSS.n11 VSS.n10 0.331382
R57 VSS.n9 VSS.n8 0.315756
R58 VSS.n12 VSS.n11 0.230486
R59 VSS.n13 VSS.n12 0.203325
R60 VSS VSS.n14 0.120789
R61 VSS.n14 VSS.n13 0.098289
C0 D a_238_448# 0.00526f
C1 D a_42_158# 0.09428f
C2 VDD a_856_452# 0.00107f
C3 a_692_96# a_274_122# 0.0035f
C4 VDD X 0.12847f
C5 a_692_96# a_754_96# 0.00178f
C6 a_274_122# a_692_452# 0.00867f
C7 a_692_452# A 0.00104f
C8 a_274_122# A 0.42638f
C9 a_274_122# a_238_448# 0
C10 SEL VDD 0.11899f
C11 a_692_452# a_754_96# 0
C12 a_274_122# a_754_96# 0.31352f
C13 a_42_158# a_274_122# 0.3235f
C14 SEL a_300_158# 0.01726f
C15 A a_754_96# 0.01799f
C16 a_42_158# a_238_448# 0.00464f
C17 D SEL 0.04436f
C18 VDD B 0.0609f
C19 a_402_448# VDD 0.00169f
C20 a_402_158# a_300_158# 0.00322f
C21 a_274_122# a_856_452# 0.00467f
C22 B a_300_158# 0.06356f
C23 a_402_448# a_300_158# 0.00817f
C24 a_856_452# A 0
C25 a_274_122# X 0
C26 D a_402_448# 0
C27 a_856_452# a_754_96# 0.0057f
C28 VDD a_300_158# 0.27305f
C29 X a_754_96# 0.09924f
C30 D VDD 0.43552f
C31 a_274_122# a_856_96# 0
C32 D a_300_158# 0.14965f
C33 a_274_122# SEL 0.06446f
C34 a_274_122# a_238_158# 0.00465f
C35 a_856_96# a_754_96# 0.00516f
C36 a_402_158# a_274_122# 0.00633f
C37 a_42_158# SEL 0.18296f
C38 a_274_122# B 0.13781f
C39 a_42_158# a_238_158# 0
C40 A B 0.15075f
C41 VDD a_692_452# 0
C42 a_274_122# VDD 0.36837f
C43 B a_754_96# 0.31243f
C44 a_42_158# a_402_448# 0.00305f
C45 a_692_452# a_300_158# 0
C46 a_274_122# a_300_158# 0.68498f
C47 VDD A 0.40874f
C48 a_238_448# VDD 0
C49 VDD a_754_96# 0.16891f
C50 a_42_158# VDD 0.21723f
C51 D a_274_122# 0.0762f
C52 A a_300_158# 0.07818f
C53 a_238_448# a_300_158# 0.00117f
C54 a_42_158# a_300_158# 0.366f
C55 a_300_158# a_754_96# 0.00226f
C56 X VSS 0.33485f
C57 A VSS 0.47304f
C58 B VSS 0.09896f
C59 SEL VSS 0.61081f
C60 D VSS 0.11746f
C61 VDD VSS 0.24098f
C62 a_856_96# VSS 0.00299f
C63 a_692_96# VSS 0.0028f
C64 a_238_158# VSS 0.00164f
C65 a_692_452# VSS 0
C66 a_754_96# VSS 0.30438f
C67 a_238_448# VSS 0
C68 a_42_158# VSS 0.17857f
C69 a_300_158# VSS 0.16376f
C70 a_274_122# VSS 0.62814f
C71 VDD.t4 VSS 0.03313f
C72 VDD.n0 VSS 0.05735f
C73 VDD.t1 VSS 0.05116f
C74 VDD.n1 VSS 0.11719f
C75 VDD.t2 VSS 0.05045f
C76 VDD.n2 VSS 0.08561f
C77 VDD.n3 VSS 0.02924f
C78 VDD.t0 VSS 1.55426f
C79 VDD.n4 VSS 0.17805f
C80 VDD.n5 VSS 0.0136f
C81 D.t0 VSS 0.41254f
C82 D.n0 VSS 0.31698f
C83 SEL.t0 VSS 0.36682f
C84 B.t1 VSS 0.1415f
C85 B.t0 VSS 0.14104f
C86 B.n0 VSS 0.41531f
C87 A.t0 VSS 0.68352f
C88 X.t1 VSS 0.07963f
C89 X.t0 VSS 0.05055f
C90 X.n0 VSS 0.08031f
.ends
