* NGSPICE file created from SwitchMatrixMultiplexer_inv_rcx.ext - technology: ihp-sg13g2

.subckt SwitchMatrixMultiplexer_inv_rcx D A VDD B X VSS SEL
X0 a_300_158# a_274_122# a_238_158# VSS.t0 sg13_lv_nmos ad=0.1045p pd=0.93u as=49.5f ps=0.73u w=0.55u l=0.13u
X1 a_402_158# D.t0 a_300_158# VSS.t12 sg13_lv_nmos ad=49.5f pd=0.73u as=0.1045p ps=0.93u w=0.55u l=0.13u
X2 X.t1 A.t0 a_692_96# VSS.t11 sg13_lv_nmos ad=0.1045p pd=0.93u as=49.5f ps=0.73u w=0.55u l=0.13u
X3 VSS.t7 SEL.t0 a_42_158# VSS.t9 sg13_lv_nmos ad=0.1045p pd=0.93u as=0.187p ps=1.78u w=0.55u l=0.13u
X4 VSS.t4 SEL.t0 a_402_158# VSS.t10 sg13_lv_nmos ad=0.19125p pd=1.33u as=49.5f ps=0.73u w=0.55u l=0.13u
X5 a_274_122# a_300_158# VSS.t4 VSS.t3 sg13_lv_nmos ad=0.16545p pd=1.27u as=0.19125p ps=1.33u w=0.86u l=0.13u
X6 a_692_96# a_300_158# a_274_122# VSS.t5 sg13_lv_nmos ad=49.5f pd=0.73u as=0.16545p ps=1.27u w=0.55u l=0.13u
X7 a_238_158# a_42_158# VSS.t7 VSS.t6 sg13_lv_nmos ad=49.5f pd=0.73u as=0.1045p ps=0.93u w=0.55u l=0.13u
X8 a_856_96# B.t0 X.t1 VSS.t8 sg13_lv_nmos ad=49.5f pd=0.73u as=0.1045p ps=0.93u w=0.55u l=0.13u
X9 VSS.t2 a_274_122# a_856_96# VSS.t1 sg13_lv_nmos ad=0.209p pd=1.86u as=49.5f ps=0.73u w=0.55u l=0.13u
X10 a_300_158# a_274_122# a_238_448# VDD.t0 sg13_lv_pmos ad=0.1596p pd=1.22u as=75.59999f ps=1.02u w=0.84u l=0.13u
X11 VDD.t1 a_274_122# a_856_452# VDD.t0 sg13_lv_pmos ad=0.3116p pd=2.4u as=73.8f ps=1u w=0.82u l=0.13u
X12 a_402_448# D.t0 a_300_158# VDD.t0 sg13_lv_pmos ad=75.59999f pd=1.02u as=0.1596p ps=1.22u w=0.84u l=0.13u
X13 a_692_452# a_300_158# a_274_122# VDD.t0 sg13_lv_pmos ad=73.8f pd=1u as=0.2395p ps=1.65u w=0.82u l=0.13u
X14 VDD.t4 SEL.t0 a_42_158# VDD.t0 sg13_lv_pmos ad=0.1596p pd=1.22u as=0.2856p ps=2.36u w=0.84u l=0.13u
X15 VDD.t2 a_42_158# a_402_448# VDD.t0 sg13_lv_pmos ad=0.2434p pd=1.71u as=75.59999f ps=1.02u w=0.84u l=0.13u
X16 X.t0 B.t1 a_692_452# VDD.t0 sg13_lv_pmos ad=0.1558p pd=1.2u as=73.8f ps=1u w=0.82u l=0.13u
X17 a_238_448# SEL.t0 VDD.t4 VDD.t0 sg13_lv_pmos ad=75.59999f pd=1.02u as=0.1596p ps=1.22u w=0.84u l=0.13u
X18 a_856_452# A.t0 X.t0 VDD.t0 sg13_lv_pmos ad=73.8f pd=1u as=0.1558p ps=1.2u w=0.82u l=0.13u
X19 a_274_122# a_300_158# VDD.t2 VDD.t0 sg13_lv_pmos ad=0.2395p pd=1.65u as=0.2434p ps=1.71u w=1.24u l=0.13u
R0 X.n0 X.t0 18.5449
R1 X.n0 X.t1 17.0005
R2 X X.n0 0.1105
R3 A A.t0 15.7294
R4 B.n0 B.t1 15.1854
R5 B.n0 B.t0 15.0005
R6 B B.n0 0.0309255
R7 SEL SEL.t0 15.0428
R8 D.n0 D.t0 15.1896
R9 D.n0 D 0.116
R10 D D.n0 0.0520625
R11 VDD.n1 VDD.t1 17.9261
R12 VDD.n0 VDD.t4 17.5574
R13 VDD.n2 VDD.t2 17.4849
R14 VDD.n5 VDD.n4 8.47111
R15 VDD.n4 VDD.n3 4.17719
R16 VDD.n4 VDD.n1 3.30918
R17 VDD.n4 VDD.t0 1.54595
R18 VDD.n2 VDD.n1 0.323251
R19 VDD.n3 VDD.n0 0.262011
R20 VDD.n3 VDD.n2 0.21278
R21 VDD VDD.n5 0.120789
R22 VDD.n5 VDD.n0 0.098289
R23 VSS.t6 VSS.n3 602.072
R24 VSS.t10 VSS.n1 568.966
R25 VSS.n7 VSS.t11 554.188
R26 VSS.t8 VSS.t1 458.128
R27 VSS.n6 VSS.t5 406.404
R28 VSS.n6 VSS.t3 391.627
R29 VSS.t12 VSS.n2 391.627
R30 VSS.t0 VSS.n2 362.07
R31 VSS.n4 VSS.t0 347.291
R32 VSS.t3 VSS.n1 317.735
R33 VSS.n5 VSS.t12 317.735
R34 VSS.t5 VSS.n0 302.957
R35 VSS.n7 VSS.t8 199.507
R36 VSS.t11 VSS.n0 155.173
R37 VSS.n5 VSS.t10 140.394
R38 VSS.n3 VSS.t9 119.234
R39 VSS.n4 VSS.t6 110.838
R40 VSS.n8 VSS.t1 68.3369
R41 VSS.n9 VSS.t2 17.6389
R42 VSS.n12 VSS.t7 17.3601
R43 VSS.n10 VSS.t4 17.2882
R44 VSS.n8 VSS.n4 17.0005
R45 VSS.n8 VSS.n2 17.0005
R46 VSS.n8 VSS.n5 17.0005
R47 VSS.n8 VSS.n1 17.0005
R48 VSS.n8 VSS.n6 17.0005
R49 VSS.n8 VSS.n0 17.0005
R50 VSS.n8 VSS.n7 17.0005
R51 VSS.n8 VSS.n3 13.0636
R52 VSS.n13 VSS.n8 8.47111
R53 VSS.n11 VSS.n8 5.61485
R54 VSS.n9 VSS.n8 2.73022
R55 VSS.n10 VSS.n9 0.297791
R56 VSS.n11 VSS.n10 0.230486
R57 VSS.n12 VSS.n11 0.203325
R58 VSS VSS.n13 0.120789
R59 VSS.n13 VSS.n12 0.098289
C0 a_274_122# D 0.07582f
C1 VDD A 0.40874f
C2 a_238_448# a_300_158# 0.00117f
C3 a_692_96# X 0.00562f
C4 a_274_122# VDD 0.37835f
C5 X a_300_158# 0.00457f
C6 a_274_122# a_402_158# 0.00633f
C7 a_402_448# D 0
C8 D VDD 0.43552f
C9 X a_692_452# 0.0013f
C10 a_692_452# a_300_158# 0
C11 a_274_122# a_856_96# 0
C12 X B 0.34069f
C13 a_402_448# VDD 0.00169f
C14 B a_300_158# 0.06356f
C15 X a_856_452# 0.0057f
C16 a_238_158# a_42_158# 0
C17 a_274_122# SEL 0.06446f
C18 a_274_122# a_42_158# 0.3235f
C19 D SEL 0.04436f
C20 D a_42_158# 0.09428f
C21 X A 0.02561f
C22 A a_300_158# 0.07818f
C23 a_274_122# a_238_448# 0
C24 VDD SEL 0.11899f
C25 a_402_448# a_42_158# 0.00305f
C26 VDD a_42_158# 0.21721f
C27 D a_238_448# 0.00526f
C28 a_692_452# A 0.00104f
C29 a_692_96# a_274_122# 0
C30 a_274_122# X 0.35137f
C31 a_274_122# a_300_158# 0.70921f
C32 A B 0.14955f
C33 D a_300_158# 0.15062f
C34 a_274_122# a_692_452# 0.00867f
C35 A a_856_452# 0
C36 VDD a_238_448# 0
C37 a_274_122# B 0.13748f
C38 a_402_448# a_300_158# 0.00817f
C39 VDD X 0.07724f
C40 VDD a_300_158# 0.2732f
C41 a_274_122# a_856_452# 0.00467f
C42 a_402_158# a_300_158# 0.00322f
C43 SEL a_42_158# 0.18296f
C44 VDD a_692_452# 0
C45 VDD B 0.06099f
C46 X a_856_96# 0.00593f
C47 a_238_448# a_42_158# 0.00464f
C48 VDD a_856_452# 0.00107f
C49 a_274_122# A 0.42426f
C50 a_300_158# SEL 0.01733f
C51 a_274_122# a_238_158# 0.00465f
C52 a_300_158# a_42_158# 0.36729f
C53 X VSS 0.43018f
C54 A VSS 0.47111f
C55 B VSS 0.09269f
C56 SEL VSS 0.61082f
C57 D VSS 0.11751f
C58 VDD VSS 0.26919f
C59 a_238_158# VSS 0.00164f
C60 a_238_448# VSS 0
C61 a_42_158# VSS 0.17841f
C62 a_300_158# VSS 0.16461f
C63 a_274_122# VSS 0.65843f
C64 VDD.t4 VSS 0.03254f
C65 VDD.n0 VSS 0.05631f
C66 VDD.t1 VSS 0.03293f
C67 VDD.n1 VSS 0.09721f
C68 VDD.t2 VSS 0.04954f
C69 VDD.n2 VSS 0.08084f
C70 VDD.n3 VSS 0.02871f
C71 VDD.t0 VSS 1.40881f
C72 VDD.n4 VSS 0.1601f
C73 VDD.n5 VSS 0.01336f
C74 D.t0 VSS 0.41284f
C75 D.n0 VSS 0.31721f
C76 SEL.t0 VSS 0.36688f
C77 B.t1 VSS 0.14673f
C78 B.t0 VSS 0.14626f
C79 B.n0 VSS 0.43067f
C80 A.t0 VSS 0.68623f
C81 X.t0 VSS 0.18764f
C82 X.t1 VSS 0.11871f
C83 X.n0 VSS 0.44069f
.ends
