* NGSPICE file created from latch_rcx.ext - technology: ihp-sg13g2

.subckt latch_rcx Q D VSS VDD GATE
X0 a_388_448# D.t0 a_286_162# VDD.t0 sg13_lv_pmos ad=75.59999f pd=1.02u as=0.1596p ps=1.22u w=0.84u l=0.13u
X1 VDD.t3 a_28_162# a_388_448# VDD.t0 sg13_lv_pmos ad=0.2621p pd=1.71u as=75.59999f ps=1.02u w=0.84u l=0.13u
X2 Q.t1 a_286_162# VSS.t1 VSS.t3 sg13_lv_nmos ad=0.2992p pd=2.44u as=0.19525p ps=1.35u w=0.88u l=0.13u
X3 Q.t0 a_286_162# VDD.t3 VDD.t0 sg13_lv_pmos ad=0.4216p pd=3.16u as=0.2621p ps=1.71u w=1.24u l=0.13u
X4 a_224_162# a_28_162# VSS.t2 VSS.t0 sg13_lv_nmos ad=49.5f pd=0.73u as=0.1045p ps=0.93u w=0.55u l=0.13u
X5 a_286_162# Q.t2 a_224_162# VSS.t0 sg13_lv_nmos ad=0.1045p pd=0.93u as=49.5f ps=0.73u w=0.55u l=0.13u
X6 VDD.t1 GATE.t0 a_28_162# VDD.t0 sg13_lv_pmos ad=0.1596p pd=1.22u as=0.2856p ps=2.36u w=0.84u l=0.13u
X7 a_388_162# D.t0 a_286_162# VSS.t0 sg13_lv_nmos ad=49.5f pd=0.73u as=0.1045p ps=0.93u w=0.55u l=0.13u
X8 VSS.t1 GATE.t0 a_388_162# VSS.t0 sg13_lv_nmos ad=0.19525p pd=1.35u as=49.5f ps=0.73u w=0.55u l=0.13u
X9 VSS.t2 GATE.t0 a_28_162# VSS.t0 sg13_lv_nmos ad=0.1045p pd=0.93u as=0.187p ps=1.78u w=0.55u l=0.13u
X10 a_224_448# GATE.t0 VDD.t1 VDD.t0 sg13_lv_pmos ad=75.59999f pd=1.02u as=0.1596p ps=1.22u w=0.84u l=0.13u
X11 a_286_162# Q.t2 a_224_448# VDD.t0 sg13_lv_pmos ad=0.1596p pd=1.22u as=75.59999f ps=1.02u w=0.84u l=0.13u
R0 Q.n0 Q.t2 17.2349
R1 Q.n1 Q.t1 8.46067
R2 Q.n0 Q.t0 6.50234
R3 Q Q.n1 0.148247
R4 Q.n1 Q.n0 0.0961417
R5 GATE GATE.t0 15.0505
R6 D.n0 D.t0 15.1896
R7 D.n0 D 0.161833
R8 D D.n0 0.0520625
R9 VDD.n0 VDD.t1 17.5574
R10 VDD.n1 VDD.t3 8.97831
R11 VDD.n3 VDD.n2 8.47111
R12 VDD.n2 VDD.n1 3.34133
R13 VDD.n2 VDD.t0 2.42907
R14 VDD.n1 VDD.n0 0.303442
R15 VDD VDD.n3 0.120789
R16 VDD.n3 VDD.n0 0.080789
R17 VSS.n4 VSS.t3 718.75
R18 VSS.t3 VSS.t0 128.906
R19 VSS.n9 VSS.t2 17.3601
R20 VSS.n2 VSS.t1 17.2882
R21 VSS.n7 VSS.n6 17.0005
R22 VSS.n5 VSS.n2 8.57339
R23 VSS.n5 VSS.n4 8.50175
R24 VSS.n4 VSS.n3 8.501
R25 VSS.n10 VSS.n0 8.47161
R26 VSS.n8 VSS.n1 8.47111
R27 VSS.n4 VSS.n0 5.66767
R28 VSS.n8 VSS.n7 0.180789
R29 VSS.n9 VSS.n8 0.160789
R30 VSS VSS.n10 0.120789
R31 VSS.n10 VSS.n9 0.080789
R32 VSS.n7 VSS.n2 0.078
R33 VSS.n6 VSS.n5 0.00124911
R34 VSS.n6 VSS.n3 0.001
R35 VSS.n1 VSS.n0 0.001
R36 VSS.n3 VSS.n1 0.001
C0 GATE D 0.04509f
C1 Q a_224_448# 0
C2 a_286_162# a_224_448# 0
C3 a_28_162# VDD 0.20982f
C4 Q D 0.07676f
C5 a_224_162# Q 0.00465f
C6 a_286_162# a_388_448# 0.00817f
C7 a_286_162# D 0.17754f
C8 Q GATE 0.06521f
C9 a_224_448# a_28_162# 0.00395f
C10 a_388_448# VDD 0.00178f
C11 a_286_162# GATE 0.01657f
C12 D VDD 0.46836f
C13 a_388_448# a_28_162# 0.00305f
C14 a_28_162# D 0.12678f
C15 a_224_162# a_28_162# 0
C16 a_286_162# Q 0.65893f
C17 GATE VDD 0.11781f
C18 a_388_162# Q 0.00595f
C19 GATE a_28_162# 0.19379f
C20 a_224_448# D 0.00587f
C21 Q VDD 0.175f
C22 a_286_162# a_388_162# 0.00199f
C23 a_388_448# D 0
C24 Q a_28_162# 0.3232f
C25 a_286_162# VDD 0.21756f
C26 a_286_162# a_28_162# 0.36438f
C27 Q VSS 0.78048f
C28 GATE VSS 0.64826f
C29 D VSS 0.1446f
C30 VDD VSS 0.16488f
C31 a_224_162# VSS 0.00158f
C32 a_224_448# VSS 0
C33 a_28_162# VSS 0.17087f
C34 a_286_162# VSS 0.10596f
C35 VDD.t1 VSS 0.02965f
C36 VDD.n0 VSS 0.05279f
C37 VDD.t3 VSS 0.04966f
C38 VDD.n1 VSS 0.08693f
C39 VDD.t0 VSS 0.85593f
C40 VDD.n2 VSS 0.09308f
C41 VDD.n3 VSS 0.0101f
C42 D.t0 VSS 0.43622f
C43 D.n0 VSS 0.36136f
C44 GATE.t0 VSS 0.36337f
C45 Q.t2 VSS 0.19042f
C46 Q.t0 VSS 0.25807f
C47 Q.n0 VSS 0.57248f
C48 Q.t1 VSS 0.16928f
C49 Q.n1 VSS 0.04819f
.ends
