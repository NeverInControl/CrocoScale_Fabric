* NGSPICE file created from mux_rcx.ext - technology: ihp-sg13g2

.subckt mux_rcx VSS VDD X A SEL B
X0 a_286_96# A.t0 a_224_456# VDD.t0 sg13_lv_pmos ad=0.1938p pd=1.4u as=91.8f ps=1.2u w=1.02u l=0.13u
X1 VSS.t4 SEL.t0 a_388_96# VSS.t3 sg13_lv_nmos ad=0.1759p pd=1.29u as=61.19999f ps=0.86u w=0.68u l=0.13u
X2 a_388_456# B.t0 a_286_96# VDD.t0 sg13_lv_pmos ad=91.8f pd=1.2u as=0.1938p ps=1.4u w=1.02u l=0.13u
X3 a_388_96# B.t0 a_286_96# VSS.t6 sg13_lv_nmos ad=61.19999f pd=0.86u as=0.1292p ps=1.06u w=0.68u l=0.13u
X4 VDD.t1 a_28_96# a_388_456# VDD.t0 sg13_lv_pmos ad=0.265p pd=1.71u as=91.8f ps=1.2u w=1.02u l=0.13u
X5 X.t0 a_286_96# VSS.t4 VSS.t7 sg13_lv_nmos ad=0.2788p pd=2.32u as=0.1759p ps=1.29u w=0.82u l=0.13u
X6 X.t1 a_286_96# VDD.t1 VDD.t0 sg13_lv_pmos ad=0.4216p pd=3.16u as=0.265p ps=1.71u w=1.24u l=0.13u
X7 VDD.t2 SEL.t1 a_28_96# VDD.t0 sg13_lv_pmos ad=0.1938p pd=1.4u as=0.3468p ps=2.72u w=1.02u l=0.13u
X8 a_286_96# A.t0 a_224_96# VSS.t5 sg13_lv_nmos ad=0.1292p pd=1.06u as=61.19999f ps=0.86u w=0.68u l=0.13u
X9 VSS.t1 SEL.t1 a_28_96# VSS.t2 sg13_lv_nmos ad=0.1292p pd=1.06u as=0.2312p ps=2.04u w=0.68u l=0.13u
X10 a_224_96# a_28_96# VSS.t1 VSS.t0 sg13_lv_nmos ad=61.19999f pd=0.86u as=0.1292p ps=1.06u w=0.68u l=0.13u
X11 a_224_456# SEL.t1 VDD.t2 VDD.t0 sg13_lv_pmos ad=91.8f pd=1.2u as=0.1938p ps=1.4u w=1.02u l=0.13u
R0 X.t1 X.n0 17.0005
R1 X.n0 X.t0 9.34067
R2 X X.t1 8.55796
R3 X X.n0 0.168119
R4 B B.t0 15.0931
R5 A A.t0 15.0738
R6 SEL.n0 SEL.t0 15.9395
R7 SEL.n0 SEL.t1 15.0005
R8 SEL SEL.n0 0.0605
R9 VDD.n7 VDD.t1 17.174
R10 VDD.n10 VDD.n9 17.001
R11 VDD.n5 VDD.n1 17.0005
R12 VDD.n1 VDD.n0 17.0005
R13 VDD.n4 VDD.t2 8.71077
R14 VDD.n8 VDD.n7 8.58089
R15 VDD.t0 VDD.n2 8.501
R16 VDD.n9 VDD.t0 8.501
R17 VDD.n6 VDD.n3 8.47111
R18 VDD.t0 VDD.n8 5.66767
R19 VDD.n6 VDD.n5 0.180789
R20 VDD.n7 VDD.n6 0.130789
R21 VDD.n10 VDD.n0 0.1205
R22 VDD.n5 VDD.n4 0.1005
R23 VDD VDD.n10 0.0605
R24 VDD.n4 VDD.n0 0.0205
R25 VDD.n8 VDD.n3 0.001
R26 VDD.n3 VDD.n2 0.001
R27 VDD.n9 VDD.n1 0.001
R28 VDD.n2 VDD.n1 0.001
R29 VSS.t3 VSS.n0 677.316
R30 VSS.t0 VSS.n2 500.99
R31 VSS.t5 VSS.n1 465.517
R32 VSS.n4 VSS.t6 421.183
R33 VSS.t6 VSS.n1 288.178
R34 VSS.n3 VSS.t5 243.843
R35 VSS.n3 VSS.t0 214.286
R36 VSS.n2 VSS.t2 162.732
R37 VSS.n0 VSS.t7 147.614
R38 VSS.n4 VSS.t3 36.9463
R39 VSS.n6 VSS.t4 17.2878
R40 VSS.n5 VSS.n3 17.0005
R41 VSS.n5 VSS.n1 17.0005
R42 VSS.n5 VSS.n4 17.0005
R43 VSS.n5 VSS.n0 11.7117
R44 VSS.n5 VSS.n2 10.6978
R45 VSS.n7 VSS.t1 8.71077
R46 VSS.n8 VSS.n5 8.47111
R47 VSS.n6 VSS.n5 3.34984
R48 VSS.n7 VSS.n6 0.295479
R49 VSS VSS.n8 0.120789
R50 VSS.n8 VSS.n7 0.080789
C0 a_28_96# a_388_456# 0.00432f
C1 SEL X 0
C2 a_286_96# A 0.00712f
C3 X a_388_456# 0
C4 a_286_96# a_224_96# 0.00146f
C5 a_224_456# VDD 0.00621f
C6 a_286_96# a_28_96# 0.30045f
C7 a_286_96# X 0.36515f
C8 a_28_96# A 0.19829f
C9 B SEL 0.21292f
C10 a_28_96# a_224_96# 0
C11 a_388_96# B 0
C12 a_28_96# X 0
C13 SEL a_224_456# 0
C14 B a_286_96# 0.15255f
C15 B A 0.08583f
C16 B a_224_96# 0.00198f
C17 B a_28_96# 0.10829f
C18 a_286_96# a_224_456# 0.00307f
C19 SEL VDD 0.14526f
C20 B X 0
C21 VDD a_388_456# 0.00329f
C22 a_28_96# a_224_456# 0.00722f
C23 a_286_96# VDD 0.25856f
C24 A VDD 0.06687f
C25 SEL a_388_456# 0
C26 a_388_96# SEL 0
C27 a_28_96# VDD 0.33446f
C28 X VDD 0.08141f
C29 a_286_96# SEL 0.1616f
C30 a_286_96# a_388_456# 0.0079f
C31 A SEL 0.22614f
C32 a_388_96# a_286_96# 0.00682f
C33 a_224_96# SEL 0.00193f
C34 a_28_96# SEL 0.49679f
C35 B VDD 0.05349f
C36 X VSS 0.24544f
C37 B VSS 0.35574f
C38 A VSS 0.19841f
C39 SEL VSS 0.27126f
C40 VDD VSS 0.14492f
C41 a_388_96# VSS 0
C42 a_224_96# VSS 0.00579f
C43 a_286_96# VSS 0.31802f
C44 a_28_96# VSS 0.41009f
C45 VDD.n0 VSS 0.00897f
C46 VDD.n1 VSS 0.02097f
C47 VDD.n3 VSS 0.02097f
C48 VDD.t1 VSS 0.03865f
C49 VDD.t2 VSS 0.0285f
C50 VDD.n4 VSS 0.02313f
C51 VDD.n5 VSS 0.01924f
C52 VDD.n6 VSS 0.01678f
C53 VDD.n7 VSS 0.04856f
C54 VDD.n8 VSS 0.02123f
C55 VDD.t0 VSS 0.67667f
C56 VDD.n9 VSS 0.01049f
C57 VDD.n10 VSS 0.01153f
C58 SEL.t0 VSS 0.17058f
C59 SEL.t1 VSS 0.5821f
C60 SEL.n0 VSS 0.4126f
C61 A.t0 VSS 0.44608f
C62 B.t0 VSS 0.3622f
C63 X.t0 VSS 0.10441f
C64 X.n0 VSS 0.11507f
C65 X.t1 VSS 0.14873f
.ends
